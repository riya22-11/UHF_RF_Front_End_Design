# Ansys Electronics Desktop project, version 2024.2
project variables:
  $SElement_Files_Index = index sta(i=true, int=false, Dist='Uniform', Tol='5%', StdD='1', Min='-3', Max='3', Shape='1', Scale='0.1', Location='0', Dataset='', LatinHypercube='true', VarMin='-1', VarMax='1', Prob='0', Mean='0') into 0  # statistics -3..3
  $SElement_Files_Index1 = index sta(i=true, int=false, Dist='Uniform', Tol='5%', StdD='1', Min='-3', Max='3', Shape='1', Scale='0.1', Location='0', Dataset='', LatinHypercube='true', VarMin='-1', VarMax='1', Prob='0', Mean='0') into 0  # statistics -3..3
  $SElement_Files_Index2 = index sta(i=true, int=false, Dist='Uniform', Tol='5%', StdD='1', Min='-3', Max='3', Shape='1', Scale='0.1', Location='0', Dataset='', LatinHypercube='true', VarMin='-1', VarMax='1', Prob='0', Mean='0') into 0  # statistics -3..3
  $pf_6_8 = 0  # statistics -3..3
  $SElement_Files_Index3 = index sta(i=true, int=false, Dist='Uniform', Tol='5%', StdD='1', Min='-3', Max='3', Shape='1', Scale='0.1', Location='0', Dataset='', LatinHypercube='true', VarMin='-1', VarMax='1', Prob='0', Mean='0') into 0  # statistics -3..3
  $SElement_Files_Index4 = index sta(i=true, int=false, Dist='Uniform', Tol='5%', StdD='1', Min='-3', Max='3', Shape='1', Scale='0.1', Location='0', Dataset='', LatinHypercube='true', VarMin='-1', VarMax='1', Prob='0', Mean='0') into 0  # statistics -3..3
  $SElement_Files_Index5 = index sta(i=true, int=false, Dist='Uniform', Tol='5%', StdD='1', Min='-3', Max='3', Shape='1', Scale='0.1', Location='0', Dataset='', LatinHypercube='true', VarMin='-1', VarMax='1', Prob='0', Mean='0') into 0  # statistics -3..3
  $SElement_Files_Index6 = index sta(i=true, int=false, Dist='Uniform', Tol='5%', StdD='1', Min='-3', Max='3', Shape='1', Scale='0.1', Location='0', Dataset='', LatinHypercube='true', VarMin='-1', VarMax='1', Prob='0', Mean='0') into 0  # statistics -3..3
  $SElement_Files_Index7 = index ArrayVarName='$SElement_Files7' into 0
  $SElement_Files_Index8 = index ArrayVarName='$SElement_Files8' into 0
  $SElement_Files_Index9 = index ArrayVarName='$SElement_Files9' into 0
  $SElement_Files_Index10 = index ArrayVarName='$SElement_Files10' into 0
materials:
  copper: permeability=0.999991 conductivity=58000000
  vacuum: permittivity=1

design Match_1 (Circuit)
options: SParamCircuitDef IntegrationMethod=FFT
variables:
  e = 2e-11
components:
  C49 = CAP_(C=3.9pF)
  C1 = CAP_(C="(6.2-0.1) pF")
  L53 = IND_(L=36n)
  port Port1 rz=29.17ohm iz=33.64ohm EnableNoise=false noisetemp=16.85cel
  port Port2 rz=50ohm iz=0ohm EnableNoise=false noisetemp=16.85cel
nets:
  0: C1.0
  net_8: L53.0, C49.1
  Port1: C49.0
  Port2: C1.1, L53.1
setups:
  LinearFrequency: LinearFrequencyData(false, 0.1, false, "", false) SweepDefinition{Variable=Freq Data="LIN 0.2GHz 1GHz 10MHz"}
reports:
  Z Parameter Plot 1: dB(Z(Port1,Port1)) vs Freq on LinearFrequency : LinearFrequency; markers MX1 at x=3.95e+08, MX2 at x=4.05e+08
  S Parameter Chart 1: S(Port1,Port1) on LinearFrequency : LinearFrequency [Freq=all]
  S Parameter Plot 1: dB(S(Port1,Port1)) vs Freq on LinearFrequency : LinearFrequency; markers MX1 at x=4.0070274e+08, MX2 at x=4.1026001e+08
  S Parameter Plot 2: dB(S(Port2,Port2)) vs Freq on LinearFrequency : LinearFrequency; markers MX1 at x=4.0014055e+08, MX2 at x=4.1e+08

design Match_1_LPF (Circuit)
options: SParamCircuitDef IntegrationMethod=FFT
variables:
  l1 = 20n
  C1 = 3.6pF
  L2 = 17n
  C2 = 6.8pF
  C3 = 22pF
components:
  C2 = CAP_(C=C1)
  C3 = CAP_(C=C2)
  L1 = IND_(L=L2)
  L2 = IND_(L=L2)
  L3 = IND_(L=l2)
  C1 = CAP_(C=C3)
  C4 = CAP_(C=C2)
  port Port1 rz=50ohm iz=0ohm EnableNoise=false noisetemp=16.85cel
  port Port3 rz=29.17ohm iz=33.64ohm EnableNoise=false noisetemp=16.85cel
nets:
  0: C1.0, C4.0, C3.0
  net_12: C3.1, L1.1, L2.0
  net_18: C1.1, L3.0, L2.1
  net_9: C2.1, L1.0
  Port1: C4.1, L3.1
  Port3: C2.0
setups:
  LinearFrequency: LinearFrequencyData(false, 0.1, false, "", false) SweepDefinition{Variable=Freq Data="LIN 0GHz 1MHz 1MHz LIN 1MHz 10GHz 10MHz"}
reports:
  S Parameter Plot 1: dB(S(Port3,Port3)) vs Freq on LinearFrequency : LinearFrequency; markers MX1 at x=4.0014055e+08
  S Parameter Plot 2: dB(S(Port1,Port1)) vs Freq on LinearFrequency : LinearFrequency; markers MX1 at x=4.0126493e+08, MX2 at x=4.1e+08
  S Parameter Plot 3: dB(S(Port3,Port1)) vs Freq on LinearFrequency : LinearFrequency; markers MX1 at x=4.9245052e+08
  S Parameter Plot 4: dB(S(Port1,Port3)) vs Freq on LinearFrequency : LinearFrequency; markers MX1 at x=4.9245052e+08
  S Parameter Chart 1: S(Port1,Port1) on LinearFrequency : LinearFrequency [Freq=all]; markers m1 at 0.401GHz

design Match_2 (Circuit)
options: SParamCircuitDef IntegrationMethod=FFT
components:
  C49 = CAP_(C=6.8p)
  L53 = IND_(L=22n)
  port Port1 rz=29.17ohm iz=33.64ohm EnableNoise=false noisetemp=16.85cel
  port Port2 rz=50ohm iz=0ohm EnableNoise=false noisetemp=16.85cel
nets:
  0: L53.1
  Port1: C49.0
  Port2: C49.1, L53.0
setups:
  LinearFrequency: LinearFrequencyData(false, 0.1, false, "", false) SweepDefinition{Variable=Freq Data="LIN 0.2GHz 1GHz 10MHz"}
reports:
  S Parameter Plot 1: dB(S(Port1,Port1)) vs Freq on LinearFrequency : LinearFrequency; markers MX1 at x=4e+08, MX2 at x=4.1e+08
  S Parameter Plot 2: dB(S(Port2,Port2)) vs Freq on LinearFrequency : LinearFrequency; markers MX1 at x=4.0014055e+08, MX2 at x=4.1026001e+08

design Match_2_LPF (Circuit)
options: SParamCircuitDef IntegrationMethod=FFT
variables:
  C1 = 6.8pF  # statistics -3..3
  L1 = 22n  # statistics -3..3
  C2 = 10pF  # statistics -3..3
  C3 = 18pF  # statistics -3..3
components:
  L53 = IND_(L=L1)
  C6 = CAP_(C=C3)
  L1 = IND_(L=L1)
  C7 = CAP_(C=C2)
  L3 = IND_(L=L1)
  C8 = CAP_(C=C2)
  C1 = CAP_(C=C1)
  port Port1 rz=29.17ohm iz=33.64ohm EnableNoise=false noisetemp=16.85cel
  port Port3 rz=50ohm iz=0ohm EnableNoise=false noisetemp=16.85cel
nets:
  0: L53.1, C8.0, C6.0, C7.0
  net_11: C6.1, L1.0, L3.1
  Port1: C1.1
  Port3: L1.1, C7.1
  Port5: C1.0, L53.0, C8.1, L3.0
setups:
  LinearFrequency: LinearFrequencyData(false, 0.1, false, "", false) SweepDefinition{Variable=Freq Data="LIN 0GHz 1MHz 1MHz LIN 1MHz 10GHz 10MHz"}
optimetrics:
  StatisticalSetup1: Statistical UseFastCalculationUpdateAlgo MaxIterations=250 SeedValue=1769626667
    calculate dB(S(Port1,Port1)) on LinearFrequency : LinearFrequency at Freq 0.401GHz
reports:
  S Parameter Plot 2: dB(S(Port1,Port1)) vs Freq on LinearFrequency : LinearFrequency; markers MX1 at x=4.01e+08
  S Parameter Plot 3: dB(S(Port1,Port3)) vs Freq on LinearFrequency : LinearFrequency; markers MX1 at x=4.01e+08
  S Parameter Plot 4: dB(S(Port3,Port3)) vs Freq on LinearFrequency : LinearFrequency; markers MX1 at x=4.01e+08
  S Parameter Chart 1: S(Port1,Port1) on LinearFrequency : LinearFrequency [Freq=all]; markers m1 at 0.401GHz

design Match_LPF_1_1 (Circuit)
options: SParamCircuitDef IntegrationMethod=FFT
components:
  S341 = Model3()
  S342 = Model4()
  S343 = Model4()
  S344 = Model4()
  S345 = Model5()
  S346 = Model5()
  S347 = Model6()
  port Port3 rz=29.17ohm iz=33.16ohm EnableNoise=false noisetemp=16.85cel
  port Port4 rz=50ohm iz=0ohm EnableNoise=false noisetemp=16.85cel
nets:
  0: S342.1, S347.0, S346.0, S345.0
  net_1: S342.0, S343.0, S341.1, S345.1
  net_6: S343.1, S344.0, S347.1
  Port3: S341.0
  Port4: S344.1, S346.1
setups:
  LinearFrequency: LinearFrequencyData(false, 0.1, false, "", false) SweepDefinition{Variable=Freq Data="LIN 0GHz 1MHz 1MHz LIN 1MHz 10GHz 10MHz"}
reports:
  S Parameter Plot 1: dB(S(Port3,Port3)) vs Freq on LinearFrequency : LinearFrequency; markers MX1 at x=4.01e+08
  S Parameter Plot 2: dB(S(Port4,Port3)) vs Freq on LinearFrequency : LinearFrequency; markers MX1 at x=4.01e+08
  S Parameter Plot 3: dB(S(Port4,Port4)) vs Freq on LinearFrequency : LinearFrequency; markers MX1 at x=4.01e+08
  S Parameter Chart 1: S(Port3,Port3) on LinearFrequency : LinearFrequency [Freq=all]; markers m1 at 0.401GHz

design Match_LPF_1_2 (Circuit)
options: SParamCircuitDef IntegrationMethod=FFT
components:
  S350 = Model7()
  S351 = Model8()
  S352 = Model8()
  S353 = Model8()
  S354 = Model9()
  S356 = Model9()
  S357 = Model10()
  port Port1 rz=29.17ohm iz=33.16ohm EnableNoise=false noisetemp=16.85cel
  port Port2 rz=50ohm iz=0ohm EnableNoise=false noisetemp=16.85cel
nets:
  0: S357.0, S354.0, S356.0
  net_1: S351.0, S350.Port2
  net_2: S354.1, S352.0, S351.1
  net_3: S357.1, S352.1, S353.0
  Port1: S350.Port1
  Port2: S353.1, S356.1
setups:
  LinearFrequency: LinearFrequencyData(false, 0.1, false, "", false) SweepDefinition{Variable=Freq Data="LIN 0GHz 1MHz 1MHz LIN 1MHz 10GHz 10MHz"}
reports:
  S Parameter Plot 1: dB(S(Port1,Port1)) vs Freq on LinearFrequency : LinearFrequency; markers MX1 at x=4.01e+08
  S Parameter Plot 2: dB(S(Port2,Port2)) vs Freq on LinearFrequency : LinearFrequency; markers MX1 at x=4.01e+08
  S Parameter Plot 3: dB(S(Port2,Port1)) vs Freq on LinearFrequency : LinearFrequency; markers MX1 at x=4.01e+08
  S-Parameters: S(Port1,Port1) on LinearFrequency : LinearFrequency [Freq=all]; markers m1 at 0.401GHz
