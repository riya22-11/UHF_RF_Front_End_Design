# Ansys Electronics Desktop project, version 2024.2

design Circuit1 (Circuit)
options: SParamCircuitDef IntegrationMethod=FFT
variables:
  c2 = 15pF
  l1 = 70n
  c1 = 6.6pF
  l2 = 11n
components:
  L1 = IND_(L=20n)
  C1 = CAP_(C=12pF)
  L2 = IND_(L=12nH)
  C2 = CAP_(C=12pF)
  L3 = IND_(L=20n)
  C3 = CAP_(C=12pF)
  port Port1 rz=29.17ohm iz=33.64ohm EnableNoise=false noisetemp=16.85cel
  port Port2 rz=50ohm iz=0ohm EnableNoise=false noisetemp=16.85cel
nets:
  0: L1.0, C3.0, L2.0, C2.0, L3.0, C1.0
  Port1: port Port2, L1.1, C3.1, L2.1, C2.1, L3.1, C1.1
setups:
  LinearFrequency: LinearFrequencyData(false, 0.1, false, "", false) SweepDefinition{Variable=Freq Data="LIN 0GHz 1MHz 1MHz LIN 1MHz 10GHz 10MHz"}
reports:
  S Parameter Plot 1: dB(S(Port1,Port1)) vs Freq on LinearFrequency : LinearFrequency; markers MX1 at x=4.01e+08
  S Parameter Plot 2: dB(S(Port1,Port1)), dB(S(Port2,Port1)) vs Freq on LinearFrequency : LinearFrequency; markers MX1 at x=4.01e+08, MY1 at y=-0.255116
  S Parameter Plot 3: dB(S(Port1,Port1)), dB(S(Port2,Port1)) vs Freq on LinearFrequency : LinearFrequency; markers MX1 at x=4.01e+08
  S Parameter Plot 4: dB(S(Port2,Port1)) vs Freq on LinearFrequency : LinearFrequency; markers MY1 at y=-0.707

design Circuit2 (Circuit)
options: SParamCircuitDef IntegrationMethod=FFT
components:
  L1 = IND_(L=18n)
  C1 = CAP_(C=6.4pF)
  C2 = CAP_(C=2.6pF)
  C3 = CAP_(C=2.6pF)
  port Port1 rz=29.17ohm iz=33.64ohm EnableNoise=false noisetemp=16.85cel
  port Port2 rz=50ohm iz=0ohm EnableNoise=false noisetemp=16.85cel
nets:
  0: C2.1, C3.1
  net_8: L1.1, C1.1
  Port1: L1.0, C2.0
  Port2: C1.0, C3.0
setups:
  LinearFrequency: LinearFrequencyData(false, 0.1, false, "", false) SweepDefinition{Variable=Freq Data="LIN 0GHz 1MHz 1MHz LIN 1MHz 10GHz 10MHz"}
reports:
  S Parameter Plot 1: dB(S(Port1,Port1)) vs Freq on LinearFrequency : LinearFrequency; markers MX1 at x=4.01e+08
  S Parameter Plot 2: dB(S(Port2,Port1)) vs Freq on LinearFrequency : LinearFrequency; markers MX1 at x=3.9205492e+08, MX2 at x=4.0704291e+08, MY1 at y=0.0703347
  S Parameter Plot 3: dB(S(Port2,Port2)) vs Freq on LinearFrequency : LinearFrequency; markers MX1 at x=4.01e+08
  S Parameter Plot 4: dB(S(Port1,Port2)) vs Freq on LinearFrequency : LinearFrequency; markers MX1 at x=3.8734607e+08, MX2 at x=4.1007011e+08

design Simsurf (Circuit)
options: SParamCircuitDef IntegrationMethod=FFT
components:
  S242 = 18n()
  S243 = 6()
  S244 = 2()
  S1 = 2()
  port Port1 rz=29.17ohm iz=33.64ohm EnableNoise=false noisetemp=16.85cel
  port Port2 rz=50ohm iz=0ohm EnableNoise=false noisetemp=16.85cel
nets:
  0: S244.1, S1.1
  net_8: S242.1, S243.0
  Port1: S242.0, S244.0
  Port2: S243.1, S1.0
setups:
  LinearFrequency: LinearFrequencyData(false, 0.1, false, "", false) SweepDefinition{Variable=Freq Data="LIN 0GHz 1MHz 1MHz LIN 1MHz 10GHz 10MHz"}
reports:
  S Parameter Plot 1: dB(S(Port1,Port1)) vs Freq on LinearFrequency : LinearFrequency; markers MX1 at x=4.01e+08
  S Parameter Plot 2: dB(S(Port2,Port1)) vs Freq on LinearFrequency : LinearFrequency; markers MX1 at x=3.8694722e+08, MX2 at x=4.0951661e+08, MX3 at x=5.4881052e+09
  S Parameter Plot 3: dB(S(Port2,Port2)) vs Freq on LinearFrequency : LinearFrequency; markers MX1 at x=4.01e+08
  S Parameter Plot 4: dB(S(Port1,Port2)) vs Freq on LinearFrequency : LinearFrequency; markers MX1 at x=3.8159123e+08, MX2 at x=4.1354346e+08, MX3 at x=5.4881052e+09
