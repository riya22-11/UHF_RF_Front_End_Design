# Ansys Electronics Desktop project, version 2024.2

design Match_1 (Circuit)
options: SParamCircuitDef IntegrationMethod=FFT
variables:
  c3 = 9.8pF
  c2 = 9.1p
components:
  C146 = CAP_(C=2.6pF)
  C147 = CAP_(C=5.1pF)
  L149 = IND_(L=72n)
  C1 = CAP_(C=0.96pF)
  R153 = RES_(R=488)
  L148 = IND_(L=62n)
  port Port1 rz=50ohm iz=0ohm EnableNoise=false noisetemp=16.85cel
nets:
  0: C147.0
  net_11: L149.1, C1.1, C146.1, R153.1
  net_6: L149.0, C1.0, C147.1, R153.0, L148.0
  Port1: C146.0, L148.1
setups:
  LinearFrequency: LinearFrequencyData(false, 0.1, false, "", false) SweepDefinition{Variable=Freq Data="LIN 0GHz 1MHz 1MHz LIN 1MHz 10GHz 10MHz"}
reports:
  S Parameter Plot 1: dB(S(Port1,Port1)) vs Freq on LinearFrequency : LinearFrequency; markers MX1 at x=4.01e+08, MX2 at x=2.0013996e+09
  S Parameter Chart 1: S(Port1,Port1) on LinearFrequency : LinearFrequency [Freq=all]; markers m1 at 0.401GHz, m2 at 0.401GHz

design Match_2 (Circuit)
options: SParamCircuitDef IntegrationMethod=FFT
variables:
  c2 = 2.4pF
  l1 = 75n
  l2 = 68n
  c1 = 5.6pF
components:
  C46 = CAP_(C=c2)
  L47 = IND_(L=l2)
  L1 = IND_(L=l1)
  C1 = CAP_(C=c1)
  port Port1 rz=29.17ohm iz=33.64ohm EnableNoise=false noisetemp=16.85cel RefNode=Port3
  port Port2 rz=50ohm iz=0ohm EnableNoise=false noisetemp=16.85cel
  port Port3 rz=29.17ohm iz=33.64ohm EnableNoise=false noisetemp=16.85cel
nets:
  0: C1.0
  Port1: C46.0, L1.1
  Port2: L47.1, C46.1
  Port3: L47.0, C1.1, L1.0
setups:
  LinearFrequency: LinearFrequencyData(false, 0.1, false, "", false) SweepDefinition{Variable=Freq Data="LIN 0GHz 1MHz 1MHz LIN 1MHz 10GHz 10MHz"}
reports:
  S Parameter Plot 1: dB(S(Port1,Port1)) vs Freq on LinearFrequency : LinearFrequency; markers MX1 at x=4.01e+08
  S Parameter Plot 2: dB(S(Port2,Port1)) vs Freq on LinearFrequency : LinearFrequency; markers MX1 at x=4.01e+08
  S Parameter Plot 3: dB(S(Port2,Port2)) vs Freq on LinearFrequency : LinearFrequency; markers MX1 at x=4.01e+08, MY1 at y=-15
  S Parameter Chart 1: S(Port1,Port1) on LinearFrequency : LinearFrequency [Freq=all]
  S Parameter Plot 4: dB(S(Port1,Port1)), dB(S(Port3,Port3)) vs Freq on LinearFrequency : LinearFrequency

design Match_3 (Circuit)
options: SParamCircuitDef IntegrationMethod=FFT
variables:
  c2 = 15pF
  l2 = 11n
  l1 = 70n
  c1 = 6.6pF
  l3 = 39n
components:
  C46 = CAP_(C=c2)
  L1 = IND_(L=l1)
  C1 = CAP_(C=c1)
  L2 = IND_(L=l2)
  C2 = CAP_(C=c2)
  L3 = IND_(L=l1)
  C3 = CAP_(C=c1)
  port Port1 rz=29.17ohm iz=33.64ohm EnableNoise=false noisetemp=16.85cel
  port Port2 rz=50ohm iz=0ohm EnableNoise=false noisetemp=16.85cel
nets:
  0: C1.0, L3.1, C3.0, L1.0
  net_4: C1.1, C46.1, L2.0
  net_7: C3.1, C2.0, L2.1
  Port1: C46.0, L1.1
  Port2: L3.0, C2.1
setups:
  LinearFrequency: LinearFrequencyData(false, 0.1, false, "", false) SweepDefinition{Variable=Freq Data="LIN 0GHz 1MHz 1MHz LIN 1MHz 10GHz 10MHz"}
reports:
  S Parameter Plot 1: dB(S(Port1,Port1)) vs Freq on LinearFrequency : LinearFrequency; markers MX1 at x=4.01e+08, MY1 at y=-20
  S Parameter Plot 2: dB(S(Port2,Port1)) vs Freq on LinearFrequency : LinearFrequency; markers MX1 at x=4.01e+08
  S Parameter Chart 1: S(Port1,Port1) on LinearFrequency : LinearFrequency [Freq=all]

design Circuit2 (Circuit)
options: SParamCircuitDef IntegrationMethod=FFT
components:
  C1 = CAP_(C=0.96pF)
  R153 = RES_(R=488)
  S198 = 5()
  S200 = 3()
  S201 = 62n1()
  S202 = 72n()
  port Port1 rz=50ohm iz=0ohm EnableNoise=false noisetemp=16.85cel
nets:
  0: S198.1
  net_11: C1.1, R153.1, S200.1, S202.0
  net_6: S198.0, S201.1, C1.0, R153.0, S202.1
  Port1: S201.0, S200.0
setups:
  LinearFrequency: LinearFrequencyData(false, 0.1, false, "", false) SweepDefinition{Variable=Freq Data="LIN 0GHz 1MHz 1MHz LIN 1MHz 10GHz 10MHz"}
reports:
  S Parameter Plot 1: dB(S(Port1,Port1)) vs Freq on LinearFrequency : LinearFrequency; markers MX1 at x=4.01e+08
  S Parameter Chart 1: S(Port1,Port1) on LinearFrequency : LinearFrequency [Freq=all]; markers m1 at 0.401GHz
